* C:\FOSSEE\eSim\library\SubcircuitLibrary\CD4085B\CD4085B.cir

* EESchema Netlist Version 1.1 (Spice format) creation date: 06/20/25 21:32:25

* To exclude a component from the Spice Netlist add [Spice_Netlist_Enabled] user FIELD set to: N
* To reorder the component spice node sequence add [Spice_Node_Sequence] user FIELD and define sequence: 2,1,0

* Sheet Name: /
M3  Net-_M11-Pad1_ /A1 /VDD /VDD eSim_MOS_P
M11  Net-_M11-Pad1_ /B1 /VDD /VDD eSim_MOS_P
M12  Net-_M11-Pad1_ /A1 Net-_M12-Pad3_ /VSS eSim_MOS_N
M13  Net-_M12-Pad3_ /B1 /VSS /VSS eSim_MOS_N
M4  Net-_M14-Pad1_ /C1 /VDD /VDD eSim_MOS_P
M14  Net-_M14-Pad1_ /D1 /VDD /VDD eSim_MOS_P
M15  Net-_M14-Pad1_ /C1 Net-_M15-Pad3_ /VSS eSim_MOS_N
M16  Net-_M15-Pad3_ /D1 /VSS /VSS eSim_MOS_N
M18  Net-_M18-Pad1_ Net-_M11-Pad1_ /VDD /VDD eSim_MOS_P
M22  Net-_M18-Pad1_ Net-_M14-Pad1_ /VDD /VDD eSim_MOS_P
M23  Net-_M18-Pad1_ Net-_M11-Pad1_ Net-_M23-Pad3_ /VSS eSim_MOS_N
M24  Net-_M23-Pad3_ Net-_M14-Pad1_ /VSS /VSS eSim_MOS_N
M31  Net-_M31-Pad1_ /INHIBIT1 /VDD /VDD eSim_MOS_P
M32  Net-_M26-Pad1_ Net-_M18-Pad1_ Net-_M31-Pad1_ /VDD eSim_MOS_P
M30  Net-_M26-Pad1_ Net-_M18-Pad1_ /VSS /VSS eSim_MOS_N
M26  Net-_M26-Pad1_ /INHIBIT1 /VSS /VSS eSim_MOS_N
M35  Net-_M35-Pad1_ Net-_M26-Pad1_ /VSS /VSS eSim_MOS_N
M36  Net-_M35-Pad1_ Net-_M26-Pad1_ /VDD /VDD eSim_MOS_P
M39  /E1 Net-_M35-Pad1_ /VSS /VSS eSim_MOS_N
M40  /E1 Net-_M35-Pad1_ /VDD /VDD eSim_MOS_P
U1  /A1 /B1 /E1 /E2 /A2 /B2 /VSS /C2 /D2 /INHIBIT1 /INHIBIT2 /C1 /D1 /VDD PORT
M1  Net-_M1-Pad1_ /A2 /VDD /VDD eSim_MOS_P
M5  Net-_M1-Pad1_ /B2 /VDD /VDD eSim_MOS_P
M6  Net-_M1-Pad1_ /A2 Net-_M6-Pad3_ /VSS eSim_MOS_N
M7  Net-_M6-Pad3_ /B2 /VSS /VSS eSim_MOS_N
M2  Net-_M19-Pad2_ /C2 /VDD /VDD eSim_MOS_P
M8  Net-_M19-Pad2_ /D2 /VDD /VDD eSim_MOS_P
M9  Net-_M19-Pad2_ /C2 Net-_M10-Pad1_ /VSS eSim_MOS_N
M10  Net-_M10-Pad1_ /D2 /VSS /VSS eSim_MOS_N
M17  Net-_M17-Pad1_ Net-_M1-Pad1_ /VDD /VDD eSim_MOS_P
M19  Net-_M17-Pad1_ Net-_M19-Pad2_ /VDD /VDD eSim_MOS_P
M20  Net-_M17-Pad1_ Net-_M1-Pad1_ Net-_M20-Pad3_ /VSS eSim_MOS_N
M21  Net-_M20-Pad3_ Net-_M19-Pad2_ /VSS /VSS eSim_MOS_N
M28  Net-_M28-Pad1_ /INHIBIT2 /VDD /VDD eSim_MOS_P
M29  Net-_M25-Pad1_ Net-_M17-Pad1_ Net-_M28-Pad1_ /VDD eSim_MOS_P
M27  Net-_M25-Pad1_ Net-_M17-Pad1_ /VSS /VSS eSim_MOS_N
M25  Net-_M25-Pad1_ /INHIBIT2 /VSS /VSS eSim_MOS_N
M33  Net-_M33-Pad1_ Net-_M25-Pad1_ /VSS /VSS eSim_MOS_N
M34  Net-_M33-Pad1_ Net-_M25-Pad1_ /VDD /VDD eSim_MOS_P
M37  /E2 Net-_M33-Pad1_ /VSS /VSS eSim_MOS_N
M38  /E2 Net-_M33-Pad1_ /VDD /VDD eSim_MOS_P

.end
