.title KiCad schematic
R1 Net-_Q2-Pad1_ Net-_C1-Pad1_ 50
Q2 Net-_Q2-Pad1_ Net-_Q2-Pad1_ Net-_C1-Pad1_ eSim_NPN
Q1 Net-_C1-Pad1_ Net-_Q1-Pad2_ Net-_Q1-Pad3_ eSim_NPN
C1 Net-_C1-Pad1_ Net-_C1-Pad2_ 15p
R2 Net-_Q1-Pad2_ Net-_C1-Pad2_ 2k
C2 Net-_C2-Pad1_ Net-_C2-Pad2_ 30p
R4 Net-_Q6-Pad2_ Net-_C2-Pad2_ 10k
Q4 Net-_C2-Pad1_ Net-_C2-Pad2_ Net-_Q1-Pad3_ eSim_NPN
R3 Net-_Q1-Pad2_ Net-_Q1-Pad3_ 30k
Q3 Net-_Q1-Pad2_ Net-_C2-Pad1_ Net-_C1-Pad1_ eSim_PNP
R5 Net-_Q6-Pad2_ Net-_Q1-Pad3_ 2k
U2 Net-_Q2-Pad1_ Net-_Q1-Pad3_ PORT
R7 Net-_Q6-Pad3_ Net-_Q1-Pad3_ 2.6k
Q7 Net-_Q5-Pad2_ Net-_Q5-Pad2_ Net-_Q2-Pad1_ eSim_PNP
R6 Net-_Q2-Pad1_ Net-_Q5-Pad3_ 1k
U1 Net-_Q6-Pad2_ Net-_Q2-Pad1_ zener
Q5 Net-_C2-Pad1_ Net-_Q5-Pad2_ Net-_Q5-Pad3_ eSim_PNP
Q6 Net-_Q5-Pad2_ Net-_Q6-Pad2_ Net-_Q6-Pad3_ eSim_NPN
.end
