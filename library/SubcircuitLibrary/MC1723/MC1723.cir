* C:\FOSSEE\eSim\library\SubcircuitLibrary\MC1723\MC1723.cir

* EESchema Netlist Version 1.1 (Spice format) creation date: 07/04/25 01:37:30

* To exclude a component from the Spice Netlist add [Spice_Netlist_Enabled] user FIELD set to: N
* To reorder the component spice node sequence add [Spice_Node_Sequence] user FIELD and define sequence: 2,1,0

* Sheet Name: /
D1  Net-_D1-Pad1_ /VCC eSim_Diode
R1  /VCC Net-_Q1-Pad3_ 500
Q1  Net-_Q1-Pad1_ Net-_Q1-Pad1_ Net-_Q1-Pad3_ eSim_PNP
R2  Net-_Q1-Pad1_ Net-_D1-Pad1_ 15k
J1  Net-_D1-Pad1_ /VEE /VEE eSim_NJF
Q3  Net-_C1-Pad1_ Net-_Q1-Pad1_ Net-_Q3-Pad3_ eSim_PNP
R3  /VCC Net-_Q3-Pad3_ 25k
Q2  Net-_C1-Pad1_ Net-_C1-Pad2_ /VEE eSim_NPN
Q4  /VCC Net-_C1-Pad1_ Net-_Q1-Pad1_ eSim_NPN
Q5  /VCC Net-_Q1-Pad1_ Net-_Q5-Pad3_ eSim_NPN
R5  Net-_Q5-Pad3_ Net-_D2-Pad2_ 100
D2  Net-_D2-Pad1_ Net-_D2-Pad2_ eSim_Diode
R6  Net-_D2-Pad1_ /VEE 5.0k
R4  Net-_C1-Pad2_ Net-_D2-Pad1_ 30k
C1  Net-_C1-Pad1_ Net-_C1-Pad2_ 5.0p
R8  Net-_Q7-Pad3_ /VEE 300
Q7  Net-_Q6-Pad1_ Net-_Q10-Pad2_ Net-_Q7-Pad3_ eSim_NPN
Q6  Net-_Q6-Pad1_ Net-_Q1-Pad1_ Net-_Q6-Pad3_ eSim_PNP
R7  /VCC Net-_Q6-Pad3_ 1.0k
Q8  /VCC Net-_Q6-Pad1_ Net-_Q10-Pad2_ eSim_NPN
R9  Net-_Q10-Pad2_ /VEE 20k
Q10  Net-_Q10-Pad1_ Net-_Q10-Pad2_ Net-_Q10-Pad3_ eSim_NPN
R10  Net-_Q10-Pad3_ /VEE 150
Q9  Net-_Q1-Pad1_ /NON_INV_IN Net-_Q10-Pad1_ eSim_NPN
Q12  /COMP /INV_IN Net-_Q10-Pad1_ eSim_NPN
Q11  /COMP Net-_Q1-Pad1_ Net-_Q11-Pad3_ eSim_PNP
R11  /VCC Net-_Q11-Pad3_ 1.0k
Q13  /COMP /Curr_lim /Curr_sense eSim_NPN
Q14  /VCC /COMP Net-_Q14-Pad3_ eSim_NPN
Q15  /VC Net-_Q14-Pad3_ /VO eSim_NPN
R12  Net-_Q14-Pad3_ /VO 15k
D3  /VZ /VO eSim_Diode
U1  /Curr_lim /Curr_sense /INV_IN /NON_INV_IN /VREF /VEE /VZ /VO /VC /VCC /COMP PORT
v1  Net-_D2-Pad2_ /VREF DC

.end
