.title KiCad schematic
R5 Net-_D1-Pad1_ Net-_C1-Pad1_ 1k
Q2 Net-_Q10-Pad1_ Net-_Q2-Pad2_ Net-_D1-Pad1_ eSim_NPN
Q6 Net-_Q5-Pad3_ Net-_Q18-Pad3_ Net-_Q10-Pad1_ eSim_NPN
Q3 Net-_Q3-Pad1_ Net-_Q3-Pad2_ Net-_Q10-Pad1_ eSim_NPN
Q5 Net-_Q3-Pad1_ Net-_Q1-Pad3_ Net-_Q5-Pad3_ eSim_NPN
C1 Net-_C1-Pad1_ Net-_C1-Pad2_ 3p
Q7 Net-_Q10-Pad1_ Net-_C1-Pad2_ Net-_C1-Pad1_ eSim_NPN
R3 Net-_Q2-Pad2_ Net-_Q3-Pad2_ 10.66k
R4 Net-_D1-Pad1_ Net-_Q2-Pad2_ 1.56k
D1 Net-_D1-Pad1_ Net-_D1-Pad2_ eSim_Diode
R1 Net-_D1-Pad2_ Vin 100k
Q1 Vin Net-_D1-Pad2_ Net-_Q1-Pad3_ eSim_NPN
R2 Net-_Q3-Pad2_ Net-_Q1-Pad3_ 9k
R6 Net-_Q10-Pad1_ Net-_Q18-Pad3_ 15k
R7 Net-_C1-Pad2_ Net-_Q10-Pad1_ 4.5k
Q8 Net-_C2-Pad1_ Net-_Q3-Pad1_ Net-_Q8-Pad3_ eSim_PNP
Q4 Net-_Q3-Pad1_ Net-_Q3-Pad1_ unconnected-_Q4-Pad3_ eSim_PNP
R8 Net-_Q8-Pad3_ Vin 50
Q14 Net-_C2-Pad1_ Net-_C2-Pad2_ Net-_Q14-Pad3_ eSim_NPN
R12 Vout Net-_Q14-Pad3_ 100
Q10 Net-_Q10-Pad1_ Net-_C1-Pad2_ Net-_Q10-Pad3_ eSim_NPN
Q11 Net-_Q10-Pad1_ Net-_C1-Pad2_ Net-_C3-Pad1_ eSim_NPN
Q9 Net-_C1-Pad2_ Net-_C1-Pad1_ Net-_D1-Pad1_ eSim_NPN
Q13 Net-_Q13-Pad1_ Net-_Q13-Pad2_ Net-_Q13-Pad3_ eSim_NPN
R11 Net-_C3-Pad1_ Net-_Q13-Pad3_ 17.5k
Q12 Net-_C3-Pad1_ Net-_Q10-Pad3_ Net-_Q12-Pad3_ eSim_NPN
R9 Net-_D1-Pad1_ Net-_Q10-Pad3_ 14k
R19 Vout Net-_Q13-Pad1_ 600
R25 Vout Net-_Q20-Pad3_ 0.2
R29 Net-_Q18-Pad2_ Sense 18k
U1 Vin Vout Net-_D1-Pad1_ PORT
Q20 Vin Net-_Q13-Pad1_ Net-_Q20-Pad3_ eSim_NPN
R10 Net-_D1-Pad1_ Net-_Q12-Pad3_ 1.8k
R13 Net-_D1-Pad1_ Net-_D2-Pad2_ 5k
Q15 Net-_C3-Pad2_ Net-_C3-Pad1_ Net-_D2-Pad1_ eSim_NPN
R28 Net-_Q18-Pad2_ Net-_Q18-Pad2_ 9k
R27 Net-_Q18-Pad2_ Net-_Q18-Pad2_ 9k
R26 Net-_Q18-Pad2_ Net-_Q18-Pad2_ 9k
C2 Net-_C2-Pad1_ Net-_C2-Pad2_ 1p
Q17 Vin Net-_C2-Pad1_ Net-_Q13-Pad1_ eSim_NPN
Q18 Net-_Q13-Pad1_ Net-_Q18-Pad2_ Net-_Q18-Pad3_ eSim_NPN
R23 Net-_Q13-Pad1_ Net-_C2-Pad2_ 1k
R24 Net-_C2-Pad2_ Net-_Q20-Pad3_ 680
R16 Net-_C2-Pad2_ Net-_D3-Pad1_ 27.5k
D3 Net-_D3-Pad1_ Vin eSim_Diode
C3 Net-_C3-Pad1_ Net-_C3-Pad2_ 30p
R21 Net-_Q18-Pad2_ Net-_Q18-Pad2_ 6k
R20 Net-_Q18-Pad2_ Net-_Q18-Pad2_ 3k
R18 Net-_D1-Pad1_ Net-_Q13-Pad2_ 11.66k
R22 Net-_Q18-Pad2_ Net-_Q18-Pad2_ 3k
R14 Net-_Q19-Pad3_ Net-_C2-Pad1_ 600
R17 Net-_Q13-Pad2_ Net-_Q18-Pad2_ 3.34k
R15 Net-_C3-Pad2_ Net-_Q19-Pad3_ 3k
Q16 Net-_C3-Pad2_ Net-_D2-Pad1_ Net-_D1-Pad1_ eSim_NPN
Q19 Net-_D1-Pad1_ Net-_C3-Pad2_ Net-_Q19-Pad3_ eSim_PNP
D2 Net-_D2-Pad1_ Net-_D2-Pad2_ eSim_Diode
.end
