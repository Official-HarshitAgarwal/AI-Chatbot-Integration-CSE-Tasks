* C:\FOSSEE\eSim\library\SubcircuitLibrary\MCT7800\MCT7800.cir

* EESchema Netlist Version 1.1 (Spice format) creation date: 05/28/25 23:41:19

* To exclude a component from the Spice Netlist add [Spice_Netlist_Enabled] user FIELD set to: N
* To reorder the component spice node sequence add [Spice_Node_Sequence] user FIELD and define sequence: 2,1,0

* Sheet Name: /
R1  Net-_Q16-Pad1_ Net-_D1-Pad2_ 100
R2  Net-_Q16-Pad1_ Net-_Q1-Pad1_ 500
Q1  Net-_Q1-Pad1_ Net-_D1-Pad2_ Net-_Q1-Pad3_ eSim_NPN
R3  Net-_Q1-Pad3_ Net-_Q2-Pad2_ 3.3K
R4  Net-_Q2-Pad2_ Net-_Q10-Pad2_ 2.7K
R5  Net-_Q10-Pad2_ Net-_D1-Pad1_ 500
D1  Net-_D1-Pad1_ Net-_D1-Pad2_ eSim_Diode
Q8  Net-_Q12-Pad2_ Net-_Q12-Pad2_ Net-_Q8-Pad3_ eSim_PNP
Q12  Net-_Q10-Pad1_ Net-_Q12-Pad2_ Net-_Q12-Pad3_ eSim_PNP
R13  Net-_Q16-Pad1_ Net-_Q12-Pad3_ 100K
R8  Net-_Q16-Pad1_ Net-_Q8-Pad3_ 100
Q2  Net-_Q12-Pad2_ Net-_Q2-Pad2_ Net-_Q2-Pad3_ eSim_NPN
Q10  Net-_Q10-Pad1_ Net-_Q10-Pad2_ Net-_D1-Pad1_ eSim_NPN
Q3  Net-_Q3-Pad1_ Net-_Q3-Pad2_ Net-_D1-Pad1_ eSim_NPN
R6  Net-_Q2-Pad3_ Net-_Q3-Pad1_ 1.4K
Q7  Net-_C1-Pad1_ Net-_Q3-Pad2_ Net-_Q7-Pad3_ eSim_NPN
R7  Net-_Q3-Pad2_ Net-_D1-Pad1_ 6.0K
R11  Net-_Q7-Pad3_ Net-_D1-Pad1_ 1.0K
Q4  Net-_Q2-Pad3_ Net-_Q3-Pad1_ Net-_Q3-Pad2_ eSim_NPN
R10  Net-_Q2-Pad3_ Net-_C1-Pad1_ 28K
R9  Net-_Q6-Pad2_ Net-_Q2-Pad3_ 6.0K
Q6  Net-_Q5-Pad3_ Net-_Q6-Pad2_ Net-_Q2-Pad3_ eSim_NPN
Q5  Net-_Q12-Pad2_ Net-_Q15-Pad3_ Net-_Q5-Pad3_ eSim_NPN
Q9  Net-_Q15-Pad3_ Net-_Q9-Pad2_ Net-_Q6-Pad2_ eSim_NPN
C1  Net-_C1-Pad1_ Net-_C1-Pad2_ 30p
Q11  Net-_C1-Pad2_ Net-_C1-Pad1_ Net-_Q11-Pad3_ eSim_NPN
Q14  Net-_D1-Pad1_ Net-_C1-Pad2_ Net-_Q10-Pad1_ eSim_PNP
R14  Net-_Q10-Pad1_ Net-_C1-Pad2_ 2.0K
R12  Net-_Q11-Pad3_ Net-_D1-Pad1_ 5.0K
Q13  Net-_C1-Pad2_ Net-_Q11-Pad3_ Net-_D1-Pad1_ eSim_NPN
Q16  Net-_Q16-Pad1_ Net-_Q10-Pad1_ Net-_Q16-Pad3_ eSim_NPN
Q17  Net-_Q16-Pad1_ Net-_Q16-Pad3_ Net-_Q17-Pad3_ eSim_NPN
D2  Net-_D2-Pad1_ Net-_D2-Pad2_ eSim_Diode
R15  Net-_Q16-Pad1_ Net-_D2-Pad2_ 10K
Q15  Net-_Q10-Pad1_ Net-_D2-Pad1_ Net-_Q15-Pad3_ eSim_NPN
R16  Net-_Q16-Pad3_ Net-_Q15-Pad3_ 200
R20  Net-_Q15-Pad3_ Net-_Q17-Pad3_ 0.3
R19  Net-_D2-Pad1_ Net-_Q17-Pad3_ 240
R17  Net-_Q15-Pad3_ Net-_Q9-Pad2_ 0.25K
R18  Net-_Q9-Pad2_ Net-_D1-Pad1_ 5.0K
U1  Net-_Q16-Pad1_ Net-_D1-Pad1_ Net-_Q15-Pad3_ PORT

.end
