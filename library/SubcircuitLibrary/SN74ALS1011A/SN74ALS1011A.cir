* H:\esim\eSim\library\SubcircuitLibrary\SN74ALS1011A\SN74ALS1011A.cir

* EESchema Netlist Version 1.1 (Spice format) creation date: 07/22/25 19:42:49

* To exclude a component from the Spice Netlist add [Spice_Netlist_Enabled] user FIELD set to: N
* To reorder the component spice node sequence add [Spice_Node_Sequence] user FIELD and define sequence: 2,1,0

* Sheet Name: /
SC1  Net-_SC1-Pad1_ Net-_SC1-Pad2_ Net-_SC1-Pad3_ Net-_SC1-Pad3_ sky130_fd_pr__pfet_01v8
SC2  Net-_SC1-Pad1_ Net-_SC2-Pad2_ Net-_SC1-Pad3_ Net-_SC1-Pad3_ sky130_fd_pr__pfet_01v8
SC6  Net-_SC1-Pad1_ Net-_SC5-Pad2_ Net-_SC1-Pad3_ Net-_SC1-Pad3_ sky130_fd_pr__pfet_01v8
SC3  Net-_SC1-Pad1_ Net-_SC1-Pad2_ Net-_SC3-Pad3_ Net-_SC3-Pad3_ sky130_fd_pr__nfet_01v8
SC4  Net-_SC3-Pad3_ Net-_SC2-Pad2_ Net-_SC4-Pad3_ Net-_SC4-Pad3_ sky130_fd_pr__nfet_01v8
SC5  Net-_SC4-Pad3_ Net-_SC5-Pad2_ Net-_SC11-Pad3_ Net-_SC11-Pad3_ sky130_fd_pr__nfet_01v8
SC7  Net-_SC12-Pad1_ Net-_SC7-Pad2_ Net-_SC1-Pad3_ Net-_SC1-Pad3_ sky130_fd_pr__pfet_01v8
SC8  Net-_SC12-Pad1_ Net-_SC10-Pad2_ Net-_SC1-Pad3_ Net-_SC1-Pad3_ sky130_fd_pr__pfet_01v8
SC12  Net-_SC12-Pad1_ Net-_SC11-Pad2_ Net-_SC1-Pad3_ Net-_SC1-Pad3_ sky130_fd_pr__pfet_01v8
SC9  Net-_SC12-Pad1_ Net-_SC7-Pad2_ Net-_SC10-Pad1_ Net-_SC10-Pad1_ sky130_fd_pr__nfet_01v8
SC10  Net-_SC10-Pad1_ Net-_SC10-Pad2_ Net-_SC10-Pad3_ Net-_SC10-Pad3_ sky130_fd_pr__nfet_01v8
SC11  Net-_SC10-Pad3_ Net-_SC11-Pad2_ Net-_SC11-Pad3_ Net-_SC11-Pad3_ sky130_fd_pr__nfet_01v8
SC13  Net-_SC13-Pad1_ Net-_SC13-Pad2_ Net-_SC1-Pad3_ Net-_SC1-Pad3_ sky130_fd_pr__pfet_01v8
SC14  Net-_SC13-Pad1_ Net-_SC14-Pad2_ Net-_SC1-Pad3_ Net-_SC1-Pad3_ sky130_fd_pr__pfet_01v8
SC18  Net-_SC13-Pad1_ Net-_SC17-Pad2_ Net-_SC1-Pad3_ Net-_SC1-Pad3_ sky130_fd_pr__pfet_01v8
SC15  Net-_SC13-Pad1_ Net-_SC13-Pad2_ Net-_SC15-Pad3_ Net-_SC15-Pad3_ sky130_fd_pr__nfet_01v8
SC16  Net-_SC15-Pad3_ Net-_SC14-Pad2_ Net-_SC16-Pad3_ Net-_SC16-Pad3_ sky130_fd_pr__nfet_01v8
SC17  Net-_SC16-Pad3_ Net-_SC17-Pad2_ Net-_SC11-Pad3_ Net-_SC11-Pad3_ sky130_fd_pr__nfet_01v8
X1  Net-_SC1-Pad1_ Net-_SC1-Pad3_ Net-_SC11-Pad3_ Net-_U1-Pad6_ CMOS_INVTR
X2  Net-_SC12-Pad1_ Net-_SC1-Pad3_ Net-_SC11-Pad3_ Net-_U1-Pad10_ CMOS_INVTR
X3  Net-_SC13-Pad1_ Net-_SC1-Pad3_ Net-_SC11-Pad3_ Net-_U1-Pad14_ CMOS_INVTR
U1  Net-_SC2-Pad2_ Net-_SC1-Pad2_ Net-_SC5-Pad2_ Net-_SC11-Pad3_ Net-_SC1-Pad3_ Net-_U1-Pad6_ Net-_SC10-Pad2_ Net-_SC7-Pad2_ Net-_SC11-Pad2_ Net-_U1-Pad10_ Net-_SC14-Pad2_ Net-_SC13-Pad2_ Net-_SC17-Pad2_ Net-_U1-Pad14_ PORT
scmode1  SKY130mode

.end
